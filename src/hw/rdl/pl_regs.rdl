`include "pl_regs.vh" //automatically created and added by fwk with conf variables such a C_VERSION ...

/* default values of defined variables */
`ifndef C_ID
`define C_ID 0xE1C00100
`endif
`ifndef C_VERSION
`define C_VERSION 0x00000000
`endif
`ifndef C_PRJ_ID
`define C_PRJ_ID 0xE1C00010
`endif
`ifndef C_PRJ_VERSION
`define C_PRJ_VERSION 0x00000000
`endif
`ifndef C_PRJ_TIMESTAMP
`define C_PRJ_TIMESTAMP 0x00000000
`endif
`ifndef C_PRJ_SHASUM
`define C_PRJ_SHASUM 0x00000000
`endif

/*
  module a address space
*/
addrmap pl_regs {
  name = "Example module for the example application";
  desyrdl_interface = "AXI4L";

  reg {
    desc = "Module Identification Number";
    default sw = r;
    default hw = r;
    field {} data[32] = `C_ID;
  } ID @0x00;

  reg {
    desc = "Module Version Number";
    default sw = r;
    default hw = r;
    field {} changes [8] =  `C_VERSION & 0x000000FF;
    field {} patch [8]   = (`C_VERSION & 0x0000FF00) >> 8;
    field {} minor [8]   = (`C_VERSION & 0x00FF0000) >> 16;
    field {} major [8]   = (`C_VERSION & 0xFF000000) >> 24;
  } VERSION @0x04;

  reg {
    desc="Project Identification Number";
    default sw = r;
    default hw = r;
    field {} data[32] = `C_PRJ_ID;
  } PRJ_ID @0x10;

  reg {
    desc="Project Version Number";
    default sw = r;
    default hw = r;
    field {} changes [8] =  `C_PRJ_VERSION & 0x000000FF;
    field {} patch [8]   = (`C_PRJ_VERSION & 0x0000FF00) >> 8;
    field {} minor [8]   = (`C_PRJ_VERSION & 0x00FF0000) >> 16;
    field {} major [8]   = (`C_PRJ_VERSION & 0xFF000000) >> 24;
  } PRJ_VERSION @0x14;

  reg {
    desc="Project Repository check sum.";
    default sw = r;
    default hw = r;
      field {} data[32] = `C_PRJ_SHASUM;
  } PRJ_SHASUM @0x18;

  reg {
    desc="Project compilation timestamp";
    default sw = r;
    default hw = r;
    field {} data[32] = `C_PRJ_TIMESTAMP;
  } PRJ_TIMESTAMP @0x1C;

 
 

 

reg {
    desc="ADC IDLY value";
    default sw = rw;
    default hw = r;
    default swacc=true;
    default swmod=true;
    field {} data[9];
  } adc_idlyval @0x20;


reg {
    desc="ADC IDLY strobe";
    default sw = rw;
    default hw = r;
    default swacc=true;
    default swmod=true;
    field {} data[16];
  } adc_idlystr @0x24;

reg {
    desc="ADC IDLY readback";
    default sw = r;
    default hw = w;
    field {} data[9];
  } adc_idlyrdval @0x28;




reg {
    desc="ADC SPI access";
    default sw = rw;
    default hw = rw;
    default swacc=true;
    default swmod=true;
    field {} data[32];
  } adc_spi @0x48;



reg {
    desc="IOC Access";
    default sw = rw;
    default hw = r;
    field {} data[1];
  } ioc_access @0x70;  
  
 
 
 
reg {
    desc="EVR Reset";
    default sw = rw;
    default hw = r;
    field {} data[1] = 0;
  } evr_reset @0xBC;
  
 
 
 
 
reg {
    desc="DMA Trig Count";
    default sw = r;
    default hw = w;
    field {} data[32];
  } dma_trigcnt @0x128;
   



 reg {
    desc="FP LED outputs";
    default sw = rw;
    default hw = r;
    field {} val[8];
  } FP_LEDS @0x140;




/* EVR Registers */
 reg {
    desc="Timestamp (ns)";
    default sw = r;
    default hw = w;
    field {} val[32];
  } ts_ns @0x150;

reg {
    desc="Timestamp (s)";
    default sw = r;
    default hw = w;
    field {} val[32];
  } ts_s @0x154;
  
reg {
    desc="Trigger Timestamp (ns)";
    default sw = r;
    default hw = w;
    field {} val[32];
  } trig_ts_ns @0x158;

reg {
    desc="Trigger Timestamp (s)";
    default sw = r;
    default hw = w;
    field {} val[32];
  } trig_ts_s @0x15C;  

reg {
    desc="Trigger Event Number";
    default sw = rw;
    default hw = r;
    field {} val[8];
  } trig_eventno @0x160;  

reg {
    desc="Trigger Delay";
    default sw = rw;
    default hw = r;
    field {} val[32];
  } trig_delay @0x164;  

 
 
 
/* ADC FIFO Readout Registers */
reg {
    desc="ADC FIFO Readout Enable";
    default sw = rw;
    default hw = r;
    default swmod=true; 
    field {} data[1];
  } adcfifo_streamenb @0x200;
     
reg {
    desc="ADC FIFO Reset";
    default sw = rw;
    default hw = r;
    field {} data[1];
  } adcfifo_reset @0x204;
   
reg {
    desc="ADC FIFO Data Out";
    default sw = r;
    default hw = w;
    default swacc=true;   
    field {} data[32];
  } adcfifo_data @0x208;
   
reg {
    desc="ADC FIFO Word Count";
    default sw = r;
    default hw = w;
    field {} data[32];
  } adcfifo_rdcnt @0x20C;
   
   
   
 
/* EEPROM Registers */   
   

reg {
    desc="Header";
    default sw = rw;
    default hw = r;
    field {} val[32];
} header @0x300;

reg {
    desc="TP1 Pulse Delay";
    default sw = rw;
    default hw = r;
    field {} val[32];
} tp1_pulse_delay @0x304;

reg {
    desc="TP1 Pulse Width";
    default sw = rw;
    default hw = r;
    field {} val[32];
} tp1_pulse_width @0x308;

reg {
    desc="TP1 ADC Delay";
    default sw = rw;
    default hw = r;
    field {} val[32];
} tp1_adc_delay @0x30C;

reg {
    desc="TP2 Pulse Delay";
    default sw = rw;
    default hw = r;
    field {} val[32];
} tp2_pulse_delay @0x310;

reg {
    desc="TP2 Pulse Width";
    default sw = rw;
    default hw = r;
    field {} val[32];
} tp2_pulse_width @0x314;

reg {
    desc="TP2 ADC Delay";
    default sw = rw;
    default hw = r;
    field {} val[32];
} tp2_adc_delay @0x318;

reg {
    desc="TP3 Pulse Delay";
    default sw = rw;
    default hw = r;
    field {} val[32];
} tp3_pulse_delay @0x31C;

reg {
    desc="TP3 Pulse Width";
    default sw = rw;
    default hw = r;
    field {} val[32];
} tp3_pulse_width @0x320;

reg {
    desc="TP3 ADC Delay";
    default sw = rw;
    default hw = r;
    field {} val[32];
} tp3_adc_delay @0x324;

reg {
    desc="Beam ADC Delay";
    default sw = rw;
    default hw = r;
    field {} val[32];
} beam_adc_delay @0x328;

reg {
    desc="Beam OOW Threshold";
    default sw = rw;
    default hw = r;
    field {} val[32];
} beam_oow_threshold @0x32C;

reg {
    desc="TP1 Integral Low Limit";
    default sw = rw;
    default hw = r;
    field {} val[32];
} tp1_int_low_limit @0x330;

reg {
    desc="TP1 Integral High Limit";
    default sw = rw;
    default hw = r;
    field {} val[32];
} tp1_int_high_limit @0x334;

reg {
    desc="TP2 Integral Low Limit";
    default sw = rw;
    default hw = r;
    field {} val[32];
} tp2_int_low_limit @0x338;

reg {
    desc="TP2 Integral High Limit";
    default sw = rw;
    default hw = r;
    field {} val[32];
} tp2_int_high_limit @0x33C;

reg {
    desc="TP3 Integral Low Limit";
    default sw = rw;
    default hw = r;
    field {} val[32];
} tp3_int_low_limit @0x340;

reg {
    desc="TP3 Integral High Limit";
    default sw = rw;
    default hw = r;
    field {} val[32];
} tp3_int_high_limit @0x344;

reg {
    desc="TP1 Peak Low Limit";
    default sw = rw;
    default hw = r;
    field {} val[32];
} tp1_peak_low_limit @0x348;

reg {
    desc="TP1 Peak High Limit";
    default sw = rw;
    default hw = r;
    field {} val[32];
} tp1_peak_high_limit @0x34C;

reg {
    desc="TP2 Peak Low Limit";
    default sw = rw;
    default hw = r;
    field {} val[32];
} tp2_peak_low_limit @0x350;

reg {
    desc="TP2 Peak High Limit";
    default sw = rw;
    default hw = r;
    field {} val[32];
} tp2_peak_high_limit @0x354;

reg {
    desc="TP3 Peak Low Limit";
    default sw = rw;
    default hw = r;
    field {} val[32];
} tp3_peak_low_limit @0x358;

reg {
    desc="TP3 Peak High Limit";
    default sw = rw;
    default hw = r;
    field {} val[32];
} tp3_peak_high_limit @0x35C;

reg {
    desc="TP1 FWHM Low Limit";
    default sw = rw;
    default hw = r;
    field {} val[32];
} tp1_fwhm_low_limit @0x360;

reg {
    desc="TP1 FWHM High Limit";
    default sw = rw;
    default hw = r;
    field {} val[32];
} tp1_fwhm_high_limit @0x364;

reg {
    desc="TP2 FWHM Low Limit";
    default sw = rw;
    default hw = r;
    field {} val[32];
} tp2_fwhm_low_limit @0x368;

reg {
    desc="TP2 FWHM High Limit";
    default sw = rw;
    default hw = r;
    field {} val[32];
} tp2_fwhm_high_limit @0x36C;

reg {
    desc="TP3 FWHM Low Limit";
    default sw = rw;
    default hw = r;
    field {} val[32];
} tp3_fwhm_low_limit @0x370;

reg {
    desc="TP3 FWHM High Limit";
    default sw = rw;
    default hw = r;
    field {} val[32];
} tp3_fwhm_high_limit @0x374;

reg {
    desc="TP1 Baseline Low Limit";
    default sw = rw;
    default hw = r;
    field {} val[32];
} tp1_base_low_limit @0x378;

reg {
    desc="TP1 Baseline High Limit";
    default sw = rw;
    default hw = r;
    field {} val[32];
} tp1_base_high_limit @0x37C;

reg {
    desc="TP2 Baseline Low Limit";
    default sw = rw;
    default hw = r;
    field {} val[32];
} tp2_base_low_limit @0x380;

reg {
    desc="TP2 Baseline High Limit";
    default sw = rw;
    default hw = r;
    field {} val[32];
} tp2_base_high_limit @0x384;

reg {
    desc="TP3 Baseline Low Limit";
    default sw = rw;
    default hw = r;
    field {} val[32];
} tp3_base_low_limit @0x388;

reg {
    desc="TP3 Baseline High Limit";
    default sw = rw;
    default hw = r;
    field {} val[32];
} tp3_base_high_limit @0x38C;

reg {
    desc="TP1 Positive Level";
    default sw = rw;
    default hw = r;
    field {} val[32];
} tp1_pos_level @0x390;

reg {
    desc="TP2 Positive Level";
    default sw = rw;
    default hw = r;
    field {} val[32];
} tp2_pos_level @0x394;

reg {
    desc="TP3 Positive Level";
    default sw = rw;
    default hw = r;
    field {} val[32];
} tp3_pos_level @0x398;

reg {
    desc="TP1 Negative Level";
    default sw = rw;
    default hw = r;
    field {} val[32];
} tp1_neg_level @0x39C;

reg {
    desc="TP2 Negative Level";
    default sw = rw;
    default hw = r;
    field {} val[32];
} tp2_neg_level @0x3A0;

reg {
    desc="TP3 Negative Level";
    default sw = rw;
    default hw = r;
    field {} val[32];
} tp3_neg_level @0x3A4;

reg {
    desc="Accumulator HL";
    default sw = rw;
    default hw = r;
    field {} val[32];
} accum_HL @0x3A8;

reg {
    desc="Beam HL";
    default sw = rw;
    default hw = r;
    field {} val[32];
} beam_HL @0x3AC;

reg {
    desc="Baseline Low Limit";
    default sw = rw;
    default hw = r;
    field {} val[32];
} baseline_low_limit @0x3B0;

reg {
    desc="Baseline High Limit";
    default sw = rw;
    default hw = r;
    field {} val[32];
} baseline_high_limit @0x3B4;

reg {
    desc="Charge Calibration";
    default sw = rw;
    default hw = r;
    field {} val[32];
} charge_cal @0x3B8;

reg {
    desc="Accumulator Charge Minimum";
    default sw = rw;
    default hw = r;
    field {} val[32];
} accum_q_min @0x3BC;

reg {
    desc="Accumulator Length";
    default sw = rw;
    default hw = r;
    field {} val[32];
} accum_len @0x3C0;

reg {
    desc="EEPROM CRC";
    default sw = rw;
    default hw = r;
    field {} val[32];
} crc_eeprom @0x3C4;


/* Pulse Statistics */

// Pulse Statistics 0
reg {
    desc="Pulse 0 Baseline";
    default sw = r;
    default hw = w;
    field {} val[16];
} pulse0_baseline @0x400;

reg {
    desc="Pulse 0 Integral";
    default sw = r;
    default hw = w;
    field {} val[32];
} pulse0_integral @0x404;

reg {
    desc="Pulse 0 Peak";
    default sw = r;
    default hw = w;
    field {} val[17];
} pulse0_peak @0x408;

reg {
    desc="Pulse 0 Peak Index";
    default sw = r;
    default hw = w;
    field {} val[32];
} pulse0_peak_index @0x40C;

reg {
    desc="Pulse 0 Peak Found";
    default sw = r;
    default hw = w;
    field {} val[1];
} pulse0_peak_found @0x410;

reg {
    desc="Pulse 0 Threshold";
    default sw = r;
    default hw = w;
    field {} val[16];
} pulse0_threshold @0x414;

reg {
    desc="Pulse 0 FWHM";
    default sw = r;
    default hw = w;
    field {} val[16];
} pulse0_fwhm @0x418;


// Pulse Statistics 1
reg {
    desc="Pulse 1 Baseline";
    default sw = r;
    default hw = w;
    field {} val[16];
} pulse1_baseline @0x41C;

reg {
    desc="Pulse 1 Integral";
    default sw = r;
    default hw = w;
    field {} val[32];
} pulse1_integral @0x420;

reg {
    desc="Pulse 1 Peak";
    default sw = r;
    default hw = w;
    field {} val[17];
} pulse1_peak @0x424;

reg {
    desc="Pulse 1 Peak Index";
    default sw = r;
    default hw = w;
    field {} val[32];
} pulse1_peak_index @0x428;

reg {
    desc="Pulse 1 Peak Found";
    default sw = r;
    default hw = w;
    field {} val[1];
} pulse1_peak_found @0x42C;

reg {
    desc="Pulse 1 Threshold";
    default sw = r;
    default hw = w;
    field {} val[16];
} pulse1_threshold @0x430;

reg {
    desc="Pulse 1 FWHM";
    default sw = r;
    default hw = w;
    field {} val[16];
} pulse1_fwhm @0x434;


// Pulse Statistics 2
reg {
    desc="Pulse 2 Baseline";
    default sw = r;
    default hw = w;
    field {} val[16];
} pulse2_baseline @0x438;

reg {
    desc="Pulse 2 Integral";
    default sw = r;
    default hw = w;
    field {} val[32];
} pulse2_integral @0x43C;

reg {
    desc="Pulse 2 Peak";
    default sw = r;
    default hw = w;
    field {} val[17];
} pulse2_peak @0x440;

reg {
    desc="Pulse 2 Peak Index";
    default sw = r;
    default hw = w;
    field {} val[32];
} pulse2_peak_index @0x444;

reg {
    desc="Pulse 2 Peak Found";
    default sw = r;
    default hw = w;
    field {} val[1];
} pulse2_peak_found @0x448;

reg {
    desc="Pulse 2 Threshold";
    default sw = r;
    default hw = w;
    field {} val[16];
} pulse2_threshold @0x44C;

reg {
    desc="Pulse 2 FWHM";
    default sw = r;
    default hw = w;
    field {} val[16];
} pulse2_fwhm @0x450;


// Pulse Statistics 3
reg {
    desc="Pulse 3 Baseline";
    default sw = r;
    default hw = w;
    field {} val[16];
} pulse3_baseline @0x454;

reg {
    desc="Pulse 3 Integral";
    default sw = r;
    default hw = w;
    field {} val[32];
} pulse3_integral @0x458;

reg {
    desc="Pulse 3 Peak";
    default sw = r;
    default hw = w;
    field {} val[17];
} pulse3_peak @0x45C;

reg {
    desc="Pulse 3 Peak Index";
    default sw = r;
    default hw = w;
    field {} val[32];
} pulse3_peak_index @0x460;

reg {
    desc="Pulse 3 Peak Found";
    default sw = r;
    default hw = w;
    field {} val[1];
} pulse3_peak_found @0x464;

reg {
    desc="Pulse 3 Threshold";
    default sw = r;
    default hw = w;
    field {} val[16];
} pulse3_threshold @0x468;

reg {
    desc="Pulse 3 FWHM";
    default sw = r;
    default hw = w;
    field {} val[16];
} pulse3_fwhm @0x46C;


// Pulse Statistics 4
reg {
    desc="Pulse 4 Baseline";
    default sw = r;
    default hw = w;
    field {} val[16];
} pulse4_baseline @0x470;

reg {
    desc="Pulse 4 Integral";
    default sw = r;
    default hw = w;
    field {} val[32];
} pulse4_integral @0x474;

reg {
    desc="Pulse 4 Peak";
    default sw = r;
    default hw = w;
    field {} val[17];
} pulse4_peak @0x478;

reg {
    desc="Pulse 4 Peak Index";
    default sw = r;
    default hw = w;
    field {} val[32];
} pulse4_peak_index @0x47C;

reg {
    desc="Pulse 4 Peak Found";
    default sw = r;
    default hw = w;
    field {} val[1];
} pulse4_peak_found @0x480;

reg {
    desc="Pulse 4 Threshold";
    default sw = r;
    default hw = w;
    field {} val[16];
} pulse4_threshold @0x484;

reg {
    desc="Pulse 4 FWHM";
    default sw = r;
    default hw = w;
    field {} val[16];
} pulse4_fwhm @0x488;





};
